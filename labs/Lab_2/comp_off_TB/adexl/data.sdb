ADE simulation setup
Run mode: Monte Carlo Sampling
Tests:
  Lab2:comp_off_TB:1: Lab2/comp_off_TB/schematic, simulator spectre
Global variables:
  dV = 0
  Fs = 10M
  VCM = 0.5
Corners (nominal off):
  model folders: /software/ECE/TSMC-2023/CRN65GP_2fF_1P9M_6X1Z1U_ALRDL/Models/spectre
  TT (off): temperature=27; crn65gplus_2d5_lk_v1d1.scs[tt, tt_lvt]
  FF (off): temperature=27; crn65gplus_2d5_lk_v1d1.scs[ff, ff_lvt]
  SS (off): temperature=27; crn65gplus_2d5_lk_v1d1.scs[ss, ss_lvt]
  MC mismatch: crn65gplus_2d5_lk_v1d1.scs[stat_mis, tt, tt_lvt, stat_noise]
Specs:
  Lab2:comp_off_TB:1 / offset: range -1.95m to 1.95m
Monte Carlo Sampling options: ignoremode=default, mcmethod=mismatch, mcnumpoints=10

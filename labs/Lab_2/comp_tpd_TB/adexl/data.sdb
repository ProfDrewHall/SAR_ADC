ADE simulation setup
Run mode: Single Run, Sweeps and Corners
Tests:
  Lab2:comp_tpd_TB:1: Lab2/comp_tpd_TB/schematic, simulator spectre
Global variables:
  dV = 0
  Fs = 10M
  VCM = 0.5
  tdelay = 20n
  tprd = 450n
  tf = 10p
  tr = 10p
  VIH = 500.39m
  VIL = 495m
Corners (nominal off):
  model folders: /software/ECE/TSMC-2023/CRN65GP_2fF_1P9M_6X1Z1U_ALRDL/Models/spectre
  TT: temperature=27; crn65gplus_2d5_lk_v1d1.scs[tt, tt_lvt]
  FF: temperature=27; crn65gplus_2d5_lk_v1d1.scs[ff, ff_lvt]
  SS: temperature=27; crn65gplus_2d5_lk_v1d1.scs[ss, ss_lvt]
